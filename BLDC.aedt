# Ansys Electronics Desktop project, version 2021.1
materials:
  lead: permeability=0.999983 conductivity=5000000 mass_density=11336
  mu_metal: permittivity=1 permeability{HUnit=A_per_meter BUnit=tesla curve (0, 0) (0.8, 0.080001) (1.2, 0.120002) (1.6, 0.150002) (2, 0.190002) (2.4, 0.230003) (2.8, 0.280004) (3.2, 0.300004) (3.6, 0.325004) (4, 0.350005) (4.4, 0.370005) (4.8, 0.390006) (5.2, 0.400006) (5.6, 0.410007) (6.4, 0.430008) (7.2, 0.440009) (8, 0.46001) (11.9, 0.500015) (15.9, 0.52502) (19.9, 0.540025) (23.9, 0.54503) (27.9, 0.555035) (31.8, 0.56004) (35.8, 0.565045) (39.8, 0.57005) (43.8, 0.575055) (47.7, 0.58006) (51.7, 0.585065) (55.7, 0.59007) (63.7, 0.59338) (71.6, 0.59669) (79.6, 0.6001) (119.4, 0.62015) (159.2, 0.6252) (198.9, 0.63025) (238.7, 0.6353) (278.5, 0.64035) (318.3, 0.6454) (358.1, 0.64705) (397.9, 0.6488) (437.7, 0.65055) (477.5, 0.6522) (517.3, 0.65385) (557, 0.6555) (636.6, 0.6572) (716.2, 0.6589) (795.8, 0.661) (1193.7, 0.664) (1591.5, 0.667) (1989.4, 0.67) (2387.3, 0.673) (2785.2, 0.6735) (3183.1, 0.674)} conductivity=1610000 lande_g_factor=2
  NdFe35: permittivity=1 permeability=1.0997785 conductivity=625000 magnetic_coercivity{Magnitude=-890000A_per_meter DirComp1=1 DirComp2=0 DirComp3=0} lande_g_factor=2 mass_density=7400
  vacuum: permittivity=1
  mu_metal_2DSF0.950: permeability{HUnit=A_per_meter BUnit=tesla curve (0, 0) (0.8, 0.076001) (1.2, 0.114002) (1.6, 0.142502) (2, 0.180502) (2.4, 0.218503) (2.8, 0.266004) (3.2, 0.285004) (3.6, 0.308754) (4, 0.332505) (4.4, 0.351505) (4.8, 0.370506) (5.2, 0.380006) (5.6, 0.389507) (6.4, 0.408508) (7.2, 0.418009) (8, 0.43701) (11.9, 0.475015) (15.9, 0.49877) (19.9, 0.513025) (23.9, 0.51778) (27.9, 0.527285) (31.8, 0.53204) (35.8, 0.536795) (39.8, 0.54155) (43.8, 0.546305) (47.7, 0.55106) (51.7, 0.555815) (55.7, 0.56057) (63.7, 0.563715) (71.6, 0.56686) (79.6, 0.5701) (119.4, 0.58915) (159.2, 0.59395) (198.9, 0.59875) (238.7, 0.60355) (278.5, 0.60835) (318.3, 0.61315) (358.1, 0.61472) (397.9, 0.616385) (437.7, 0.61805) (477.5, 0.61962) (517.3, 0.62119) (557, 0.62276) (636.6, 0.62438) (716.2, 0.626) (795.8, 0.628) (1193.7, 0.630875) (1591.5, 0.63375) (1989.4, 0.636625) (2387.3, 0.6395) (2785.2, 0.64) (3183.1, 0.6405) (7162.1, 0.6455)}
  NdFe35_2DSF1.000_N: CoordinateSystemType=Cylindrical permeability=1.09978 magnetic_coercivity{Magnitude=-890000A_per_meter DirComp1=1 DirComp2=0 DirComp3=0}
  NdFe35_2DSF1.000_S: CoordinateSystemType=Cylindrical permeability=1.09978 magnetic_coercivity{Magnitude=-890000A_per_meter DirComp1=-1 DirComp2=0 DirComp3=0}
  copper: permeability=0.999991 conductivity=58000000 mass_density=8933

design Maxwell2DDesign1 (Maxwell 2D, Transient, XY geometry, model units mm)
options: ModelDepth=65mm
variables:
  fractions = 4
  skew = 0
geometry:
  Band [vacuum] = user_primitive(RMxprt/Band, DiaGap=74.5mm, DiaYoke=26mm, Length=0mm, SegAngle=1deg, Fractions=1, HalfAxial=0, InfoCore=0)
  Shaft [vacuum] = user_primitive(RMxprt/Band, DiaGap=74.5mm, DiaYoke=26mm, Length=0mm, SegAngle=1deg, Fractions=1, HalfAxial=0, InfoCore=100)
  OuterRegion [vacuum] = user_primitive(RMxprt/Band, DiaGap=74.5mm, DiaYoke=120mm, Length=0mm, SegAngle=1deg, Fractions=fractions, HalfAxial=0, InfoCore=100)
  Tool = user_primitive(RMxprt/Band, DiaGap=74.5mm, DiaYoke=120mm, Length=0mm, SegAngle=1deg, Fractions=fractions, HalfAxial=0, InfoCore=1)
  Stator [mu_metal_2DSF0.950] = user_primitive(RMxprt/SlotCore, DiaGap=75mm, DiaYoke=120mm, Length=0mm, Skew=0deg, Slots=24, SlotType=2, Hs0=0.5mm, Hs01=0mm, Hs1=1mm, Hs2=8.2mm, Bs0=2.5mm, Bs1=5.6mm, Bs2=7.6mm, Rs=3.8mm, FilletType=0, HalfSlot=0, SegAngle=15deg, LenRegion=0mm, InfoCore=0)
  Coil_0 [copper] = user_primitive(RMxprt/LapCoil, DiaGap=75mm, DiaYoke=120mm, Length=0mm, Skew=0deg, Slots=24, SlotType=2, Hs0=0.5mm, Hs1=1mm, Hs2=8.2mm, Bs0=2.5mm, Bs1=5.6mm, Bs2=7.6mm, Rs=3.8mm, FilletType=0, Layers=2, CoilPitch=5, EndExt=0mm, SpanExt=0mm, BendAngle=0deg, SegAngle=5deg, LenRegion=0mm, InfoCoil=2)
  Coil_1..Coil_5 [copper], Coil_6..Coil_23 = Coil_0.duplicate_around_axis(axis=Z, angle=15deg, total=24)
  Coil_0.unite(Coil_6, Coil_12, Coil_18)
  Coil_1.unite(Coil_7, Coil_13, Coil_19)
  Coil_2.unite(Coil_8, Coil_14, Coil_20)
  Coil_3.unite(Coil_9, Coil_15, Coil_21)
  Coil_4.unite(Coil_10, Coil_16, Coil_22)
  Coil_5.unite(Coil_11, Coil_17, Coil_23)
  CoilRe_0 [copper] = user_primitive(RMxprt/LapCoil, DiaGap=75mm, DiaYoke=120mm, Length=0mm, Skew=0deg, Slots=24, SlotType=2, Hs0=0.5mm, Hs1=1mm, Hs2=8.2mm, Bs0=2.5mm, Bs1=5.6mm, Bs2=7.6mm, Rs=3.8mm, FilletType=0, Layers=2, CoilPitch=5, EndExt=0mm, SpanExt=0mm, BendAngle=0deg, SegAngle=5deg, LenRegion=0mm, InfoCoil=3)
  CoilRe_0.rotate(axis=Z, angle=-75deg)
  CoilRe_1..CoilRe_5 [copper], CoilRe_6..CoilRe_23 = CoilRe_0.duplicate_around_axis(axis=Z, angle=15deg, total=24)
  CoilRe_0.unite(CoilRe_6, CoilRe_12, CoilRe_18)
  CoilRe_1.unite(CoilRe_7, CoilRe_13, CoilRe_19)
  CoilRe_2.unite(CoilRe_8, CoilRe_14, CoilRe_20)
  CoilRe_3.unite(CoilRe_9, CoilRe_15, CoilRe_21)
  CoilRe_4.unite(CoilRe_10, CoilRe_16, CoilRe_22)
  CoilRe_5.unite(CoilRe_11, CoilRe_17, CoilRe_23)
  Rotor [mu_metal_2DSF0.950] = user_primitive(RMxprt/PMCore, DiaGap=74mm, DiaYoke=26mm, Length=0mm, Poles=4, PoleType=1, Embrace=0.7, ThickMag=3.5mm, WidthMag=0mm, Offset=0mm, Bridge=0mm, Rib=0mm, LenRegion=0mm, InfoCore=0)
  Mag_0 [NdFe35_2DSF1.000_N] = user_primitive(RMxprt/PMCore, DiaGap=74mm, DiaYoke=26mm, Length=0mm, Poles=4, PoleType=1, Embrace=0.7, ThickMag=3.5mm, WidthMag=0mm, Offset=0mm, Bridge=0mm, Rib=0mm, LenRegion=0mm, InfoCore=2)
  Mag_1, Mag_2, Mag_3 = Mag_0.duplicate_around_axis(axis=Z, angle=90deg, total=4)
  Mag_0.unite(Mag_1, Mag_2, Mag_3)
  InnerRegion [vacuum] = user_primitive(RMxprt/PMCore, DiaGap=74mm, DiaYoke=26mm, Length=0mm, Poles=4, PoleType=1, Embrace=0.7, ThickMag=3.5mm, WidthMag=0mm, Offset=0mm, Bridge=0mm, Rib=0mm, LenRegion=0mm, InfoCore=100)
  Tool_1 = Tool.copy()
  Band.subtract(Tool_1)
  Tool_2 = Tool.copy()
  InnerRegion.subtract(Tool_2)
  Tool_3 = Tool.copy()
  Shaft.subtract(Tool_3)
  Tool_4 = Tool.copy()
  Stator.subtract(Tool_4)
  Tool_5 = Tool.copy()
  Coil_0.subtract(Tool_5)
  Tool_6 = Tool.copy()
  Coil_1.subtract(Tool_6)
  Tool_7 = Tool.copy()
  Coil_2.subtract(Tool_7)
  Tool_8 = Tool.copy()
  Coil_3.subtract(Tool_8)
  Tool_9 = Tool.copy()
  Coil_4.subtract(Tool_9)
  Tool_10 = Tool.copy()
  Coil_5.subtract(Tool_10)
  Tool_11 = Tool.copy()
  CoilRe_0.subtract(Tool_11)
  Tool_12 = Tool.copy()
  CoilRe_1.subtract(Tool_12)
  Tool_13 = Tool.copy()
  CoilRe_2.subtract(Tool_13)
  Tool_14 = Tool.copy()
  CoilRe_3.subtract(Tool_14)
  Tool_15 = Tool.copy()
  CoilRe_4.subtract(Tool_15)
  Tool_16 = Tool.copy()
  CoilRe_5.subtract(Tool_16)
  Tool_17 = Tool.copy()
  Rotor.subtract(Tool_17)
  Mag_0.subtract(Tool)
  Rotor.separate_bodies()
motion:
  MotionSetup1: Band Move_Type=Rotate Coordinate_System=Global Axis=Z Is_Positive=true InitPos=15deg Angular_Velocity=257.843rpm Objects=Band
  Moving1: Moving Objects=[Shaft, Rotor, Mag_0, InnerRegion]
boundaries and excitations:
  VectorPotential1: Vector Potential Edges=OuterRegion.edge(at (42.4264, 42.4264, 0)) Value=0
  Master1: Independent Edges=OuterRegion.edge(at (30, 0, 0))
  Slave1: Dependent Edges=OuterRegion.edge(at (0, 30, 0)) ReverseU Independent=Master1 SameAsMaster=false
  PhA_0: Coil Objects=Coil_0 Conductor_number=30 Winding=PhaseA PolarityType=Positive
  PhARe_0: Coil Objects=CoilRe_5 Conductor_number=30 Winding=PhaseA PolarityType=Negative
  PhA_1: Coil Objects=Coil_1 Conductor_number=30 Winding=PhaseA PolarityType=Positive
  PhA_2: Coil Objects=Coil_2 Conductor_number=30 Winding=PhaseA PolarityType=Positive
  PhB_3: Coil Objects=Coil_3 Conductor_number=30 Winding=PhaseB PolarityType=Positive
  PhB_4: Coil Objects=Coil_4 Conductor_number=30 Winding=PhaseB PolarityType=Positive
  PhB_5: Coil Objects=Coil_5 Conductor_number=30 Winding=PhaseB PolarityType=Positive
  PhA_19: Coil Objects=CoilRe_0 Conductor_number=30 Winding=PhaseA PolarityType=Positive
  PhA_20: Coil Objects=CoilRe_1 Conductor_number=30 Winding=PhaseA PolarityType=Positive
  PhB_21: Coil Objects=CoilRe_2 Conductor_number=30 Winding=PhaseB PolarityType=Positive
  PhB_22: Coil Objects=CoilRe_3 Conductor_number=30 Winding=PhaseB PolarityType=Positive
  PhB_23: Coil Objects=CoilRe_4 Conductor_number=30 Winding=PhaseB PolarityType=Positive
  PhaseA: Winding Group Type=External IsSolid=false Current=0A ParallelBranchesNum=1
  PhaseB: Winding Group Type=External IsSolid=false Current=0A ParallelBranchesNum=1
  external circuit: "* Design: BLDC"
mesh:
  Length_Coil: LengthBased RefineInside Objects=[Coil_0..Coil_5, CoilRe_0..CoilRe_5] MaxLength=3.3mm
  Length_Mag: LengthBased RefineInside Objects=Mag_0 MaxLength=1.75mm
  SurfApprox_Mag: SurfApproxBased Objects=Mag_0 CurvedSurfaceApproxChoice=ManualSettings SurfDev=0.037mm NormalDev=15deg
  SurfApprox_Main: SurfApproxBased Objects=[Stator, Rotor, Band, OuterRegion, InnerRegion, Shaft] CurvedSurfaceApproxChoice=ManualSettings SurfDev=0.06mm NormalDev=15deg
  Length_Main: LengthBased RefineInside Objects=[Stator, Rotor, Band, OuterRegion, InnerRegion, Shaft] MaxLength=4.6mm
  initial mesh: MeshMethod=AnsoftTAU
setups:
  Setup1: Transient NonlinearSolverResidual=0.0001 StopTime=0.04s TimeStep=0.0002s SaveFieldsType=Custom SweepRanges{0s to 10000000ns step 500000ns} NumberSolveSteps=1 RangeStart=0s RangeEnd=0.1s InitialTimeStep=0.002s MinTimeStep=0.001s MaxTimeStep=0.003s TimeStepErrTolerance=0.0001
field plots:
  Flux_Lines1: A over Band.face(at (0, 0, 0)) Shaft.face(at (0, 0, 0)) OuterRegion.face(at (30, 30, 0)) Stator.face(at (0, 0, 0)) Coil_0.face(at (41.3356, 5.44193, 0)) Coil_1.face(1 of 1) Coil_2.face(1 of 1) Coil_3.face(1 of 1) Coil_4.face(1 of 1) Coil_5.face(1 of 1) CoilRe_0.face(1 of 1) CoilRe_1.face(1 of 1) CoilRe_2.face(1 of 1) CoilRe_3.face(1 of 1) CoilRe_4.face(1 of 1) CoilRe_5.face(1 of 1) Rotor.face(at (0, 0, 0)) Mag_0.face(at (25.441, 25.441, 0)) InnerRegion.face(at (0, 0, 0)) on Setup1 : Transient at Time=0.00102s
  Mag_B1: B over Band.face(at (0, 0, 0)) Shaft.face(at (0, 0, 0)) OuterRegion.face(at (30, 30, 0)) Stator.face(at (0, 0, 0)) Coil_0.face(at (41.3356, 5.44193, 0)) Coil_1.face(1 of 1) Coil_2.face(1 of 1) Coil_3.face(1 of 1) Coil_4.face(1 of 1) Coil_5.face(1 of 1) CoilRe_0.face(1 of 1) CoilRe_1.face(1 of 1) CoilRe_2.face(1 of 1) CoilRe_3.face(1 of 1) CoilRe_4.face(1 of 1) CoilRe_5.face(1 of 1) Rotor.face(at (0, 0, 0)) Mag_0.face(at (25.441, 25.441, 0)) InnerRegion.face(at (0, 0, 0)) on Setup1 : Transient at Time=0.00102s
reports:
  Torque: Moving1.Torque vs Time on Setup1 : Transient
  Winding Currents: Current(PhaseA), Current(PhaseB) vs Time on Setup1 : Transient

design RMxprtDesign1 (RMxprt, Brushless Permanent-Magnet DC Motor, model units mm)
variables:
  skew = 0
machine:
  Machine: FrictionLoss=12W WindLoss=1W ReferenceSpeed=1500rpm NumberOfPoles=4 RotorPosition=true ControlType=0 CircuitType=C2
  Circuit: TriggerPulseWidth=90deg TransistorDrop=2V DiodeDrop=2V LeadAngleOfTrigger=0deg MaximumCurrent=0A MinimumCurrent=0A
  Stator: SkewWidth=skew NumberOfSlots=24 LaminationSectors=0 PressBoardThickness=0mm OuterDiameter=120mm InnerDiameter=75mm Length=65mm StackingFactor=0.95 SteelType=mu_metal SlotType=2
  Rotor: OuterDiameter=74mm InnerDiameter=26mm Length=65mm SteelType=mu_metal PoleType=1 StackingFactor=0.95
  Shaft:
  Stator Slot: Hs0=0.5mm Hs1=1mm Hs2=8.2mm Bs0=2.5mm Bs1=5.6mm Bs2=7.6mm Rs=0mm ToothWidth=0mm
  Stator Winding: WindingType=Whole-Coiled WindingLayers=2 ParallelBranches=1 ConductorsPerSlot=60 CoilPitch=5 EndAdjustment=0mm BaseInnerRadius=0mm TipInnerDiameter=0mm EndClearance=0mm CoilWrap=0mm SlotLiner=0.3mm WedgeThickness=0mm LayerInsulation=0mm BottomInsulation=0mm LimitedFillFactor=0.75 WdgNumberofPriodicMultipler=1 NumberOfStrands=0 WireWrap=0mm InterturnInsulation=0mm WireDiameter=0mm WireWidth=0mm WireThickness=0mm Gauge=0
  Rotor Pole: Embrace=0.7 Offset=0mm ShaftDiameter=0mm Bridge=0mm Rib=0mm MagnetThickness=3.5mm MagnetWidth=0mm MagnetType=NdFe35
setups:
  Setup1: BLDC Motor RatedOutputPower=560W RatedVoltage=220V RatedSpeed=500rpm OperatingTemperature=75cel LoadType=ConstPower
