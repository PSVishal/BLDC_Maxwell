# Ansys Electronics Desktop project, version 2021.1

design BLDC (Maxwell Circuit)
variables:
  Kle = 1
components:
  Winding_2 = Winding(Name=PhaseA)
  Winding_3 = Winding(Name=PhaseB)
  Res_4 = Res(Name=A R=3.89383ohm)
  Res_5 = Res(Name=B R=3.89383ohm)
  Ind_6 = Ind(Name=A L=0.00102427H*Kle)
  Ind_7 = Ind(Name=B L=0.00102427H*Kle)
  Ammeter_8 = Ammeter(Name=IA)
  Ammeter_9 = Ammeter(Name=IB)
  VPulse_10 = VPulse(V1=-1 Td=22.5 Tr=0 Tf=0 Pw=45 Period=180 Type=POS)
  VPulse_11 = VPulse(V1=-1 Td=67.5 Tr=0 Tf=0 Pw=45 Period=180 Type=POS)
  VPulse_12 = VPulse(V1=-1 Td=112.5 Tr=0 Tf=0 Pw=45 Period=180 Type=POS)
  VPulse_13 = VPulse(V1=-1 Td=157.5 Tr=0 Tf=0 Pw=45 Period=180 Type=POS)
  Res_14 = Res()
  Res_15 = Res()
  Res_16 = Res()
  Res_17 = Res()
  VoltmeterG_18 = VoltmeterG(Name=Vc1)
  VoltmeterG_19 = VoltmeterG(Name=Vc2)
  VoltmeterG_20 = VoltmeterG(Name=Vc3)
  VoltmeterG_21 = VoltmeterG(Name=Vc4)
  VDC_22 = VDC(V=110V)
  VDC_23 = VDC(V=110V)
  DIODE_24 = DIODE(MOD=DModel1)
  DIODE_25 = DIODE(MOD=DModel1)
  DIODE_26 = DIODE(MOD=DModel1)
  DIODE_27 = DIODE(MOD=DModel1)
  DIODE_28 = DIODE(MOD=DModel1)
  DIODE_29 = DIODE(MOD=DModel1)
  DIODE_30 = DIODE(MOD=DModel1)
  DIODE_31 = DIODE(MOD=DModel1)
  DIODE_32 = DIODE(MOD=DModel1)
  DIODE_33 = DIODE(MOD=DModel1)
  DIODE_34 = DIODE(MOD=DModel1)
  DIODE_35 = DIODE(MOD=DModel1)
  DIODE_36 = DIODE(MOD=DModel1)
  DIODE_37 = DIODE(MOD=DModel1)
  DIODE_38 = DIODE(MOD=DModel1)
  DIODE_39 = DIODE(MOD=DModel1)
  SW_V_40 = SW_V(ID_V=IVc1 MOD=SModel1)
  SW_V_41 = SW_V(ID_V=IVc3 MOD=SModel1)
  SW_V_42 = SW_V(ID_V=IVc2 MOD=SModel1)
  SW_V_43 = SW_V(ID_V=IVc4 MOD=SModel1)
  SW_V_44 = SW_V(ID_V=IVc3 MOD=SModel1)
  SW_V_45 = SW_V(ID_V=IVc1 MOD=SModel1)
  SW_V_46 = SW_V(ID_V=IVc4 MOD=SModel1)
  SW_V_47 = SW_V(ID_V=IVc2 MOD=SModel1)
  DIODE_Model_48 = DIODE_Model(RS=0.0299108ohm DeviceName=DModel1)
  SW_VModel_49 = SW_VModel(Von=0V Voff=0V DeviceName=SModel1)
nets:
  0: VPulse_10.1, VPulse_11.1, VPulse_12.1, VPulse_13.1, VDC_23.0, VDC_22.1
  net_13: VoltmeterG_18.0, VPulse_10.0, Res_14.0
  net_14: VoltmeterG_19.0, VPulse_11.0, Res_15.0
  net_15: Res_16.0, VoltmeterG_20.0, VPulse_12.0
  net_16: Res_17.0, VPulse_13.0, VoltmeterG_21.0
  net_17: Res_17.1, Res_16.1, Res_15.1, Res_14.1
  net_21: DIODE_27.1, DIODE_31.1, DIODE_32.0, DIODE_29.1, DIODE_34.0, VDC_22.0, DIODE_25.1, DIODE_38.0, DIODE_36.0
  net_23: DIODE_28.0, DIODE_30.0, VDC_23.1, DIODE_24.0, DIODE_26.0, SW_V_45.1, SW_V_47.1, SW_V_43.1, SW_V_41.1
  net_24: Ammeter_8.0, DIODE_33.0, DIODE_24.1, DIODE_25.0, SW_V_40.1
  net_25: DIODE_27.0, Ammeter_9.0, DIODE_26.1, SW_V_42.1, DIODE_35.0
  net_26: Winding_2.1, DIODE_28.1, DIODE_29.0, DIODE_37.0, SW_V_44.1
  net_27: Winding_3.1, DIODE_30.1, DIODE_31.0, DIODE_39.0, SW_V_46.1
  net_3: Winding_2.0, Res_4.1
  net_32: DIODE_32.1, SW_V_40.0
  net_33: DIODE_33.1, SW_V_41.0
  net_34: DIODE_34.1, SW_V_42.0
  net_35: SW_V_43.0, DIODE_35.1
  net_36: DIODE_36.1, SW_V_44.0
  net_37: DIODE_37.1, SW_V_45.0
  net_38: SW_V_46.0, DIODE_38.1
  net_39: DIODE_39.1, SW_V_47.0
  net_4: Winding_3.0, Res_5.1
  net_5: Res_4.0, Ind_6.1
  net_6: Res_5.0, Ind_7.1
  net_7: Ammeter_8.1, Ind_6.0
  net_8: Ind_7.0, Ammeter_9.1
